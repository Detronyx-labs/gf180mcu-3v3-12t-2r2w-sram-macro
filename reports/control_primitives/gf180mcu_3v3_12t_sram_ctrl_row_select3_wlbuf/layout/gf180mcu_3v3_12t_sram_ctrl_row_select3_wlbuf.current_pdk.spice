* NGSPICE file created from gf180mcu_3v3_12t_sram_ctrl_row_select3_wlbuf.ext - technology: gf180mcuD

.subckt gf180mcu_3v3_12t_sram_ctrl_row_select3_wlbuf VDD VSS P0 P1 P2 WL
X0 a_744_5604# P0 a_600_5604# VSS nfet_03v3 ad=0.4642p pd=2.99u as=0.4642p ps=2.99u w=1.055u l=0.28u
X1 VDD a_2328_5604# WL VDD pfet_03v3 ad=0.1232p pd=1u as=0.1232p ps=1u w=0.56u l=0.28u
X2 VSS a_2328_5604# WL VSS nfet_03v3 ad=0.4642p pd=2.99u as=0.4642p ps=2.99u w=1.055u l=0.28u
X3 VSS P2 a_1176_5604# VSS nfet_03v3 ad=0.4642p pd=2.99u as=0.4642p ps=2.99u w=1.055u l=0.28u
X4 VDD P0 a_600_5604# VDD pfet_03v3 ad=0.1232p pd=1u as=0.1232p ps=1u w=0.56u l=0.28u
X5 VDD a_600_5604# a_1896_5604# VDD pfet_03v3 ad=0.1232p pd=1u as=0.1232p ps=1u w=0.56u l=0.28u
X6 VDD a_1896_5604# a_2328_5604# VDD pfet_03v3 ad=0.1232p pd=1u as=0.1232p ps=1u w=0.56u l=0.28u
X7 VDD P2 a_600_5604# VDD pfet_03v3 ad=0.1232p pd=1u as=0.1232p ps=1u w=0.56u l=0.28u
X8 VSS a_1896_5604# a_2328_5604# VSS nfet_03v3 ad=0.4642p pd=2.99u as=0.4642p ps=2.99u w=1.055u l=0.28u
X9 a_1176_5604# P1 a_744_5604# VSS nfet_03v3 ad=0.4642p pd=2.99u as=0.4642p ps=2.99u w=1.055u l=0.28u
X10 VDD P1 a_600_5604# VDD pfet_03v3 ad=0.1232p pd=1u as=0.1232p ps=1u w=0.56u l=0.28u
X11 VSS a_600_5604# a_1896_5604# VSS nfet_03v3 ad=0.4642p pd=2.99u as=0.4642p ps=2.99u w=1.055u l=0.28u
.ends
