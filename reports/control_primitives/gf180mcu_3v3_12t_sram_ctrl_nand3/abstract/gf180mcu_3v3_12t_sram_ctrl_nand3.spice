.subckt gf180mcu_3v3_12t_sram_ctrl_nand3 VDD VSS A B C Y
.ends gf180mcu_3v3_12t_sram_ctrl_nand3
