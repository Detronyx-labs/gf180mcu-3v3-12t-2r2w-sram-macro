.subckt gf180mcu_3v3_12t_sram_ctrl_nor2 VDD VSS A B Y
.ends gf180mcu_3v3_12t_sram_ctrl_nor2
