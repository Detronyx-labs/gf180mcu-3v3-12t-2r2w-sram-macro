.subckt gf180mcu_3v3_12t_sram_ctrl_inv VDD VSS A Y
.ends gf180mcu_3v3_12t_sram_ctrl_inv
