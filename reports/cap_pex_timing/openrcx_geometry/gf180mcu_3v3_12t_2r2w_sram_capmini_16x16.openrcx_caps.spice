* OpenRCX-derived synthetic capacitance netlist for current 16x16 mini-array.
* rules: <GF180MCU_PDK_ROOT>/gf180mcuD/libs.tech/openlane/rules.openrcx.gf180mcuD.nom.magic
* Units: capacitance values are in fF.
Cg0 rbl_tc0_c1_r0_rbl 0 22.428549f
Cg1 rbl_tc0_c1_r1_rbl 0 22.428549f
Cg2 rbl_tc0_c2_r0_rbl 0 22.428549f
Cg3 rbl_tc0_c2_r1_rbl 0 22.428549f
Cg4 rbl_tc0_c3_r0_rbl 0 22.428549f
Cg5 rbl_tc0_c3_r1_rbl 0 22.428549f
Cg6 rbl_tc0_r0_rbl 0 22.428549f
Cg7 rbl_tc0_r1_rbl 0 22.428549f
Cg8 rbl_tc1_c1_r0_rbl 0 22.428549f
Cg9 rbl_tc1_c1_r1_rbl 0 22.428549f
Cg10 rbl_tc1_c2_r0_rbl 0 22.428549f
Cg11 rbl_tc1_c2_r1_rbl 0 22.428549f
Cg12 rbl_tc1_c3_r0_rbl 0 22.428549f
Cg13 rbl_tc1_c3_r1_rbl 0 22.428549f
Cg14 rbl_tc1_r0_rbl 0 22.428549f
Cg15 rbl_tc1_r1_rbl 0 22.428549f
Cg16 rbl_tc2_c1_r0_rbl 0 22.428549f
Cg17 rbl_tc2_c1_r1_rbl 0 22.428549f
Cg18 rbl_tc2_c2_r0_rbl 0 22.428549f
Cg19 rbl_tc2_c2_r1_rbl 0 22.428549f
Cg20 rbl_tc2_c3_r0_rbl 0 22.428549f
Cg21 rbl_tc2_c3_r1_rbl 0 22.428549f
Cg22 rbl_tc2_r0_rbl 0 22.428549f
Cg23 rbl_tc2_r1_rbl 0 22.428549f
Cg24 rbl_tc3_c1_r0_rbl 0 22.428549f
Cg25 rbl_tc3_c1_r1_rbl 0 22.428549f
Cg26 rbl_tc3_c2_r0_rbl 0 22.428549f
Cg27 rbl_tc3_c2_r1_rbl 0 22.428549f
Cg28 rbl_tc3_c3_r0_rbl 0 22.428549f
Cg29 rbl_tc3_c3_r1_rbl 0 22.428549f
Cg30 rbl_tc3_r0_rbl 0 22.428549f
Cg31 rbl_tc3_r1_rbl 0 22.428549f
Cg32 rwl_tr0_r0_r0_rwl 0 14.3801604f
Cg33 rwl_tr0_r0_r1_rwl 0 14.3801604f
Cg34 rwl_tr0_r1_r0_rwl 0 14.3801604f
Cg35 rwl_tr0_r1_r1_rwl 0 14.3801604f
Cg36 rwl_tr0_r2_r0_rwl 0 14.3801604f
Cg37 rwl_tr0_r2_r1_rwl 0 14.3801604f
Cg38 rwl_tr0_r3_r0_rwl 0 14.3801604f
Cg39 rwl_tr0_r3_r1_rwl 0 14.3801604f
Cg40 rwl_tr1_r0_r0_rwl 0 14.3801604f
Cg41 rwl_tr1_r0_r1_rwl 0 14.3801604f
Cg42 rwl_tr1_r1_r0_rwl 0 14.3801604f
Cg43 rwl_tr1_r1_r1_rwl 0 14.3801604f
Cg44 rwl_tr1_r2_r0_rwl 0 14.3801604f
Cg45 rwl_tr1_r2_r1_rwl 0 14.3801604f
Cg46 rwl_tr1_r3_r0_rwl 0 14.3801604f
Cg47 rwl_tr1_r3_r1_rwl 0 14.3801604f
Cg48 rwl_tr2_r0_r0_rwl 0 14.3801604f
Cg49 rwl_tr2_r0_r1_rwl 0 14.3801604f
Cg50 rwl_tr2_r1_r0_rwl 0 14.3801604f
Cg51 rwl_tr2_r1_r1_rwl 0 14.3801604f
Cg52 rwl_tr2_r2_r0_rwl 0 14.3801604f
Cg53 rwl_tr2_r2_r1_rwl 0 14.3801604f
Cg54 rwl_tr2_r3_r0_rwl 0 14.3801604f
Cg55 rwl_tr2_r3_r1_rwl 0 14.3801604f
Cg56 rwl_tr3_r0_r0_rwl 0 14.3801604f
Cg57 rwl_tr3_r0_r1_rwl 0 14.3801604f
Cg58 rwl_tr3_r1_r0_rwl 0 14.3801604f
Cg59 rwl_tr3_r1_r1_rwl 0 14.3801604f
Cg60 rwl_tr3_r2_r0_rwl 0 14.3801604f
Cg61 rwl_tr3_r2_r1_rwl 0 14.3801604f
Cg62 rwl_tr3_r3_r0_rwl 0 14.3801604f
Cg63 rwl_tr3_r3_r1_rwl 0 14.3801604f
Cg64 wbl_tc0_c1_w0_bl 0 22.428549f
Cg65 wbl_tc0_c1_w0_br 0 22.428549f
Cg66 wbl_tc0_c1_w1_bl 0 22.428549f
Cg67 wbl_tc0_c1_w1_br 0 22.428549f
Cg68 wbl_tc0_c2_w0_bl 0 22.428549f
Cg69 wbl_tc0_c2_w0_br 0 22.428549f
Cg70 wbl_tc0_c2_w1_bl 0 22.428549f
Cg71 wbl_tc0_c2_w1_br 0 22.428549f
Cg72 wbl_tc0_c3_w0_bl 0 22.428549f
Cg73 wbl_tc0_c3_w0_br 0 22.428549f
Cg74 wbl_tc0_c3_w1_bl 0 22.428549f
Cg75 wbl_tc0_c3_w1_br 0 22.428549f
Cg76 wbl_tc0_w0_bl 0 22.428549f
Cg77 wbl_tc0_w0_br 0 22.428549f
Cg78 wbl_tc0_w1_bl 0 22.428549f
Cg79 wbl_tc0_w1_br 0 22.428549f
Cg80 wbl_tc1_c1_w0_bl 0 22.428549f
Cg81 wbl_tc1_c1_w0_br 0 22.428549f
Cg82 wbl_tc1_c1_w1_bl 0 22.428549f
Cg83 wbl_tc1_c1_w1_br 0 22.428549f
Cg84 wbl_tc1_c2_w0_bl 0 22.428549f
Cg85 wbl_tc1_c2_w0_br 0 22.428549f
Cg86 wbl_tc1_c2_w1_bl 0 22.428549f
Cg87 wbl_tc1_c2_w1_br 0 22.428549f
Cg88 wbl_tc1_c3_w0_bl 0 22.428549f
Cg89 wbl_tc1_c3_w0_br 0 22.428549f
Cg90 wbl_tc1_c3_w1_bl 0 22.428549f
Cg91 wbl_tc1_c3_w1_br 0 22.428549f
Cg92 wbl_tc1_w0_bl 0 22.428549f
Cg93 wbl_tc1_w0_br 0 22.428549f
Cg94 wbl_tc1_w1_bl 0 22.428549f
Cg95 wbl_tc1_w1_br 0 22.428549f
Cg96 wbl_tc2_c1_w0_bl 0 22.428549f
Cg97 wbl_tc2_c1_w0_br 0 22.428549f
Cg98 wbl_tc2_c1_w1_bl 0 22.428549f
Cg99 wbl_tc2_c1_w1_br 0 22.428549f
Cg100 wbl_tc2_c2_w0_bl 0 22.428549f
Cg101 wbl_tc2_c2_w0_br 0 22.428549f
Cg102 wbl_tc2_c2_w1_bl 0 22.428549f
Cg103 wbl_tc2_c2_w1_br 0 22.428549f
Cg104 wbl_tc2_c3_w0_bl 0 22.428549f
Cg105 wbl_tc2_c3_w0_br 0 22.428549f
Cg106 wbl_tc2_c3_w1_bl 0 22.428549f
Cg107 wbl_tc2_c3_w1_br 0 22.428549f
Cg108 wbl_tc2_w0_bl 0 22.428549f
Cg109 wbl_tc2_w0_br 0 22.428549f
Cg110 wbl_tc2_w1_bl 0 22.428549f
Cg111 wbl_tc2_w1_br 0 22.428549f
Cg112 wbl_tc3_c1_w0_bl 0 22.428549f
Cg113 wbl_tc3_c1_w0_br 0 22.428549f
Cg114 wbl_tc3_c1_w1_bl 0 22.428549f
Cg115 wbl_tc3_c1_w1_br 0 22.428549f
Cg116 wbl_tc3_c2_w0_bl 0 22.428549f
Cg117 wbl_tc3_c2_w0_br 0 22.428549f
Cg118 wbl_tc3_c2_w1_bl 0 22.428549f
Cg119 wbl_tc3_c2_w1_br 0 22.428549f
Cg120 wbl_tc3_c3_w0_bl 0 22.428549f
Cg121 wbl_tc3_c3_w0_br 0 22.428549f
Cg122 wbl_tc3_c3_w1_bl 0 22.428549f
Cg123 wbl_tc3_c3_w1_br 0 22.428549f
Cg124 wbl_tc3_w0_bl 0 22.428549f
Cg125 wbl_tc3_w0_br 0 22.428549f
Cg126 wbl_tc3_w1_bl 0 22.428549f
Cg127 wbl_tc3_w1_br 0 22.428549f
Cg128 wwl_tr0_r0_w0_wl 0 14.3801604f
Cg129 wwl_tr0_r0_w1_wl 0 14.3801604f
Cg130 wwl_tr0_r1_w0_wl 0 14.3801604f
Cg131 wwl_tr0_r1_w1_wl 0 14.3801604f
Cg132 wwl_tr0_r2_w0_wl 0 14.3801604f
Cg133 wwl_tr0_r2_w1_wl 0 14.3801604f
Cg134 wwl_tr0_r3_w0_wl 0 14.3801604f
Cg135 wwl_tr0_r3_w1_wl 0 14.3801604f
Cg136 wwl_tr1_r0_w0_wl 0 14.3801604f
Cg137 wwl_tr1_r0_w1_wl 0 14.3801604f
Cg138 wwl_tr1_r1_w0_wl 0 14.3801604f
Cg139 wwl_tr1_r1_w1_wl 0 14.3801604f
Cg140 wwl_tr1_r2_w0_wl 0 14.3801604f
Cg141 wwl_tr1_r2_w1_wl 0 14.3801604f
Cg142 wwl_tr1_r3_w0_wl 0 14.3801604f
Cg143 wwl_tr1_r3_w1_wl 0 14.3801604f
Cg144 wwl_tr2_r0_w0_wl 0 14.3801604f
Cg145 wwl_tr2_r0_w1_wl 0 14.3801604f
Cg146 wwl_tr2_r1_w0_wl 0 14.3801604f
Cg147 wwl_tr2_r1_w1_wl 0 14.3801604f
Cg148 wwl_tr2_r2_w0_wl 0 14.3801604f
Cg149 wwl_tr2_r2_w1_wl 0 14.3801604f
Cg150 wwl_tr2_r3_w0_wl 0 14.3801604f
Cg151 wwl_tr2_r3_w1_wl 0 14.3801604f
Cg152 wwl_tr3_r0_w0_wl 0 14.3801604f
Cg153 wwl_tr3_r0_w1_wl 0 14.3801604f
Cg154 wwl_tr3_r1_w0_wl 0 14.3801604f
Cg155 wwl_tr3_r1_w1_wl 0 14.3801604f
Cg156 wwl_tr3_r2_w0_wl 0 14.3801604f
Cg157 wwl_tr3_r2_w1_wl 0 14.3801604f
Cg158 wwl_tr3_r3_w0_wl 0 14.3801604f
Cg159 wwl_tr3_r3_w1_wl 0 14.3801604f
Cc160 wbl_tc0_w0_bl wbl_tc0_w1_bl 9.31032608f
Cc161 wbl_tc0_w1_bl wbl_tc0_w0_br 5.80640887f
Cc162 wbl_tc0_w0_br wbl_tc0_w1_br 9.31032608f
Cc163 wbl_tc0_w1_br rbl_tc0_r0_rbl 6.27900588f
Cc164 rbl_tc0_r0_rbl rbl_tc0_r1_rbl 12.272891f
Cc165 rbl_tc0_r1_rbl wbl_tc0_c1_w0_bl 3.80279183f
Cc166 wbl_tc0_c1_w0_bl wbl_tc0_c1_w1_bl 9.31032608f
Cc167 wbl_tc0_c1_w1_bl wbl_tc0_c1_w0_br 5.80640887f
Cc168 wbl_tc0_c1_w0_br wbl_tc0_c1_w1_br 9.31032608f
Cc169 wbl_tc0_c1_w1_br rbl_tc0_c1_r0_rbl 6.27900588f
Cc170 rbl_tc0_c1_r0_rbl rbl_tc0_c1_r1_rbl 12.272891f
Cc171 rbl_tc0_c1_r1_rbl wbl_tc0_c2_w0_bl 3.80279183f
Cc172 wbl_tc0_c2_w0_bl wbl_tc0_c2_w1_bl 9.31032608f
Cc173 wbl_tc0_c2_w1_bl wbl_tc0_c2_w0_br 5.80640887f
Cc174 wbl_tc0_c2_w0_br wbl_tc0_c2_w1_br 9.31032608f
Cc175 wbl_tc0_c2_w1_br rbl_tc0_c2_r0_rbl 6.27900588f
Cc176 rbl_tc0_c2_r0_rbl rbl_tc0_c2_r1_rbl 12.272891f
Cc177 rbl_tc0_c2_r1_rbl wbl_tc0_c3_w0_bl 3.80279183f
Cc178 wbl_tc0_c3_w0_bl wbl_tc0_c3_w1_bl 9.31032608f
Cc179 wbl_tc0_c3_w1_bl wbl_tc0_c3_w0_br 5.80640887f
Cc180 wbl_tc0_c3_w0_br wbl_tc0_c3_w1_br 9.31032608f
Cc181 wbl_tc0_c3_w1_br rbl_tc0_c3_r0_rbl 6.27900588f
Cc182 rbl_tc0_c3_r0_rbl rbl_tc0_c3_r1_rbl 12.272891f
Cc183 rbl_tc0_c3_r1_rbl wbl_tc1_w0_bl 3.80279183f
Cc184 wbl_tc1_w0_bl wbl_tc1_w1_bl 9.31032608f
Cc185 wbl_tc1_w1_bl wbl_tc1_w0_br 5.80640887f
Cc186 wbl_tc1_w0_br wbl_tc1_w1_br 9.31032608f
Cc187 wbl_tc1_w1_br rbl_tc1_r0_rbl 6.27900588f
Cc188 rbl_tc1_r0_rbl rbl_tc1_r1_rbl 12.272891f
Cc189 rbl_tc1_r1_rbl wbl_tc1_c1_w0_bl 3.80279183f
Cc190 wbl_tc1_c1_w0_bl wbl_tc1_c1_w1_bl 9.31032608f
Cc191 wbl_tc1_c1_w1_bl wbl_tc1_c1_w0_br 5.80640887f
Cc192 wbl_tc1_c1_w0_br wbl_tc1_c1_w1_br 9.31032608f
Cc193 wbl_tc1_c1_w1_br rbl_tc1_c1_r0_rbl 6.27900588f
Cc194 rbl_tc1_c1_r0_rbl rbl_tc1_c1_r1_rbl 12.272891f
Cc195 rbl_tc1_c1_r1_rbl wbl_tc1_c2_w0_bl 3.80279183f
Cc196 wbl_tc1_c2_w0_bl wbl_tc1_c2_w1_bl 9.31032608f
Cc197 wbl_tc1_c2_w1_bl wbl_tc1_c2_w0_br 5.80640887f
Cc198 wbl_tc1_c2_w0_br wbl_tc1_c2_w1_br 9.31032608f
Cc199 wbl_tc1_c2_w1_br rbl_tc1_c2_r0_rbl 6.27900588f
Cc200 rbl_tc1_c2_r0_rbl rbl_tc1_c2_r1_rbl 12.272891f
Cc201 rbl_tc1_c2_r1_rbl wbl_tc1_c3_w0_bl 3.80279183f
Cc202 wbl_tc1_c3_w0_bl wbl_tc1_c3_w1_bl 9.31032608f
Cc203 wbl_tc1_c3_w1_bl wbl_tc1_c3_w0_br 5.80640887f
Cc204 wbl_tc1_c3_w0_br wbl_tc1_c3_w1_br 9.31032608f
Cc205 wbl_tc1_c3_w1_br rbl_tc1_c3_r0_rbl 6.27900588f
Cc206 rbl_tc1_c3_r0_rbl rbl_tc1_c3_r1_rbl 12.272891f
Cc207 rbl_tc1_c3_r1_rbl wbl_tc2_w0_bl 3.80279183f
Cc208 wbl_tc2_w0_bl wbl_tc2_w1_bl 9.31032608f
Cc209 wbl_tc2_w1_bl wbl_tc2_w0_br 5.80640887f
Cc210 wbl_tc2_w0_br wbl_tc2_w1_br 9.31032608f
Cc211 wbl_tc2_w1_br rbl_tc2_r0_rbl 6.27900588f
Cc212 rbl_tc2_r0_rbl rbl_tc2_r1_rbl 12.272891f
Cc213 rbl_tc2_r1_rbl wbl_tc2_c1_w0_bl 3.80279183f
Cc214 wbl_tc2_c1_w0_bl wbl_tc2_c1_w1_bl 9.31032608f
Cc215 wbl_tc2_c1_w1_bl wbl_tc2_c1_w0_br 5.80640887f
Cc216 wbl_tc2_c1_w0_br wbl_tc2_c1_w1_br 9.31032608f
Cc217 wbl_tc2_c1_w1_br rbl_tc2_c1_r0_rbl 6.27900588f
Cc218 rbl_tc2_c1_r0_rbl rbl_tc2_c1_r1_rbl 12.272891f
Cc219 rbl_tc2_c1_r1_rbl wbl_tc2_c2_w0_bl 3.80279183f
Cc220 wbl_tc2_c2_w0_bl wbl_tc2_c2_w1_bl 9.31032608f
Cc221 wbl_tc2_c2_w1_bl wbl_tc2_c2_w0_br 5.80640887f
Cc222 wbl_tc2_c2_w0_br wbl_tc2_c2_w1_br 9.31032608f
Cc223 wbl_tc2_c2_w1_br rbl_tc2_c2_r0_rbl 6.27900588f
Cc224 rbl_tc2_c2_r0_rbl rbl_tc2_c2_r1_rbl 12.272891f
Cc225 rbl_tc2_c2_r1_rbl wbl_tc2_c3_w0_bl 3.80279183f
Cc226 wbl_tc2_c3_w0_bl wbl_tc2_c3_w1_bl 9.31032608f
Cc227 wbl_tc2_c3_w1_bl wbl_tc2_c3_w0_br 5.80640887f
Cc228 wbl_tc2_c3_w0_br wbl_tc2_c3_w1_br 9.31032608f
Cc229 wbl_tc2_c3_w1_br rbl_tc2_c3_r0_rbl 6.27900588f
Cc230 rbl_tc2_c3_r0_rbl rbl_tc2_c3_r1_rbl 12.272891f
Cc231 rbl_tc2_c3_r1_rbl wbl_tc3_w0_bl 3.80279183f
Cc232 wbl_tc3_w0_bl wbl_tc3_w1_bl 9.31032608f
Cc233 wbl_tc3_w1_bl wbl_tc3_w0_br 5.80640887f
Cc234 wbl_tc3_w0_br wbl_tc3_w1_br 9.31032608f
Cc235 wbl_tc3_w1_br rbl_tc3_r0_rbl 6.27900588f
Cc236 rbl_tc3_r0_rbl rbl_tc3_r1_rbl 12.272891f
Cc237 rbl_tc3_r1_rbl wbl_tc3_c1_w0_bl 3.80279183f
Cc238 wbl_tc3_c1_w0_bl wbl_tc3_c1_w1_bl 9.31032608f
Cc239 wbl_tc3_c1_w1_bl wbl_tc3_c1_w0_br 5.80640887f
Cc240 wbl_tc3_c1_w0_br wbl_tc3_c1_w1_br 9.31032608f
Cc241 wbl_tc3_c1_w1_br rbl_tc3_c1_r0_rbl 6.27900588f
Cc242 rbl_tc3_c1_r0_rbl rbl_tc3_c1_r1_rbl 12.272891f
Cc243 rbl_tc3_c1_r1_rbl wbl_tc3_c2_w0_bl 3.80279183f
Cc244 wbl_tc3_c2_w0_bl wbl_tc3_c2_w1_bl 9.31032608f
Cc245 wbl_tc3_c2_w1_bl wbl_tc3_c2_w0_br 5.80640887f
Cc246 wbl_tc3_c2_w0_br wbl_tc3_c2_w1_br 9.31032608f
Cc247 wbl_tc3_c2_w1_br rbl_tc3_c2_r0_rbl 6.27900588f
Cc248 rbl_tc3_c2_r0_rbl rbl_tc3_c2_r1_rbl 12.272891f
Cc249 rbl_tc3_c2_r1_rbl wbl_tc3_c3_w0_bl 3.80279183f
Cc250 wbl_tc3_c3_w0_bl wbl_tc3_c3_w1_bl 9.31032608f
Cc251 wbl_tc3_c3_w1_bl wbl_tc3_c3_w0_br 5.80640887f
Cc252 wbl_tc3_c3_w0_br wbl_tc3_c3_w1_br 9.31032608f
Cc253 wbl_tc3_c3_w1_br rbl_tc3_c3_r0_rbl 6.27900588f
Cc254 rbl_tc3_c3_r0_rbl rbl_tc3_c3_r1_rbl 12.272891f
Cc255 wwl_tr0_r0_w0_wl rwl_tr0_r0_r0_rwl 52.6631184f
Cc256 rwl_tr0_r0_r0_rwl wwl_tr0_r0_w1_wl 52.6631184f
Cc257 wwl_tr0_r0_w1_wl rwl_tr0_r0_r1_rwl 52.6631184f
Cc258 rwl_tr0_r0_r1_rwl wwl_tr0_r1_w0_wl 13.1657796f
Cc259 wwl_tr0_r1_w0_wl rwl_tr0_r1_r0_rwl 52.6631184f
Cc260 rwl_tr0_r1_r0_rwl wwl_tr0_r1_w1_wl 52.6631184f
Cc261 wwl_tr0_r1_w1_wl rwl_tr0_r1_r1_rwl 52.6631184f
Cc262 rwl_tr0_r1_r1_rwl wwl_tr0_r2_w0_wl 13.1657796f
Cc263 wwl_tr0_r2_w0_wl rwl_tr0_r2_r0_rwl 52.6631184f
Cc264 rwl_tr0_r2_r0_rwl wwl_tr0_r2_w1_wl 52.6631184f
Cc265 wwl_tr0_r2_w1_wl rwl_tr0_r2_r1_rwl 52.6631184f
Cc266 rwl_tr0_r2_r1_rwl wwl_tr0_r3_w0_wl 13.1657796f
Cc267 wwl_tr0_r3_w0_wl rwl_tr0_r3_r0_rwl 52.6631184f
Cc268 rwl_tr0_r3_r0_rwl wwl_tr0_r3_w1_wl 52.6631184f
Cc269 wwl_tr0_r3_w1_wl rwl_tr0_r3_r1_rwl 52.6631184f
Cc270 rwl_tr0_r3_r1_rwl wwl_tr1_r0_w0_wl 6.58290024f
Cc271 wwl_tr1_r0_w0_wl rwl_tr1_r0_r0_rwl 52.6631184f
Cc272 rwl_tr1_r0_r0_rwl wwl_tr1_r0_w1_wl 52.6631184f
Cc273 wwl_tr1_r0_w1_wl rwl_tr1_r0_r1_rwl 52.6631184f
Cc274 rwl_tr1_r0_r1_rwl wwl_tr1_r1_w0_wl 13.1657796f
Cc275 wwl_tr1_r1_w0_wl rwl_tr1_r1_r0_rwl 52.6631184f
Cc276 rwl_tr1_r1_r0_rwl wwl_tr1_r1_w1_wl 52.6631184f
Cc277 wwl_tr1_r1_w1_wl rwl_tr1_r1_r1_rwl 52.6631184f
Cc278 rwl_tr1_r1_r1_rwl wwl_tr1_r2_w0_wl 13.1657796f
Cc279 wwl_tr1_r2_w0_wl rwl_tr1_r2_r0_rwl 52.6631184f
Cc280 rwl_tr1_r2_r0_rwl wwl_tr1_r2_w1_wl 52.6631184f
Cc281 wwl_tr1_r2_w1_wl rwl_tr1_r2_r1_rwl 52.6631184f
Cc282 rwl_tr1_r2_r1_rwl wwl_tr1_r3_w0_wl 13.1657796f
Cc283 wwl_tr1_r3_w0_wl rwl_tr1_r3_r0_rwl 52.6631184f
Cc284 rwl_tr1_r3_r0_rwl wwl_tr1_r3_w1_wl 52.6631184f
Cc285 wwl_tr1_r3_w1_wl rwl_tr1_r3_r1_rwl 52.6631184f
Cc286 rwl_tr1_r3_r1_rwl wwl_tr2_r0_w0_wl 6.58290024f
Cc287 wwl_tr2_r0_w0_wl rwl_tr2_r0_r0_rwl 52.6631184f
Cc288 rwl_tr2_r0_r0_rwl wwl_tr2_r0_w1_wl 52.6631184f
Cc289 wwl_tr2_r0_w1_wl rwl_tr2_r0_r1_rwl 52.6631184f
Cc290 rwl_tr2_r0_r1_rwl wwl_tr2_r1_w0_wl 13.1657796f
Cc291 wwl_tr2_r1_w0_wl rwl_tr2_r1_r0_rwl 52.6631184f
Cc292 rwl_tr2_r1_r0_rwl wwl_tr2_r1_w1_wl 52.6631184f
Cc293 wwl_tr2_r1_w1_wl rwl_tr2_r1_r1_rwl 52.6631184f
Cc294 rwl_tr2_r1_r1_rwl wwl_tr2_r2_w0_wl 13.1657796f
Cc295 wwl_tr2_r2_w0_wl rwl_tr2_r2_r0_rwl 52.6631184f
Cc296 rwl_tr2_r2_r0_rwl wwl_tr2_r2_w1_wl 52.6631184f
Cc297 wwl_tr2_r2_w1_wl rwl_tr2_r2_r1_rwl 52.6631184f
Cc298 rwl_tr2_r2_r1_rwl wwl_tr2_r3_w0_wl 13.1657796f
Cc299 wwl_tr2_r3_w0_wl rwl_tr2_r3_r0_rwl 52.6631184f
Cc300 rwl_tr2_r3_r0_rwl wwl_tr2_r3_w1_wl 52.6631184f
Cc301 wwl_tr2_r3_w1_wl rwl_tr2_r3_r1_rwl 52.6631184f
Cc302 rwl_tr2_r3_r1_rwl wwl_tr3_r0_w0_wl 6.58290024f
Cc303 wwl_tr3_r0_w0_wl rwl_tr3_r0_r0_rwl 52.6631184f
Cc304 rwl_tr3_r0_r0_rwl wwl_tr3_r0_w1_wl 52.6631184f
Cc305 wwl_tr3_r0_w1_wl rwl_tr3_r0_r1_rwl 52.6631184f
Cc306 rwl_tr3_r0_r1_rwl wwl_tr3_r1_w0_wl 13.1657796f
Cc307 wwl_tr3_r1_w0_wl rwl_tr3_r1_r0_rwl 52.6631184f
Cc308 rwl_tr3_r1_r0_rwl wwl_tr3_r1_w1_wl 52.6631184f
Cc309 wwl_tr3_r1_w1_wl rwl_tr3_r1_r1_rwl 52.6631184f
Cc310 rwl_tr3_r1_r1_rwl wwl_tr3_r2_w0_wl 13.1657796f
Cc311 wwl_tr3_r2_w0_wl rwl_tr3_r2_r0_rwl 52.6631184f
Cc312 rwl_tr3_r2_r0_rwl wwl_tr3_r2_w1_wl 52.6631184f
Cc313 wwl_tr3_r2_w1_wl rwl_tr3_r2_r1_rwl 52.6631184f
Cc314 rwl_tr3_r2_r1_rwl wwl_tr3_r3_w0_wl 13.1657796f
Cc315 wwl_tr3_r3_w0_wl rwl_tr3_r3_r0_rwl 52.6631184f
Cc316 rwl_tr3_r3_r0_rwl wwl_tr3_r3_w1_wl 52.6631184f
Cc317 wwl_tr3_r3_w1_wl rwl_tr3_r3_r1_rwl 52.6631184f
