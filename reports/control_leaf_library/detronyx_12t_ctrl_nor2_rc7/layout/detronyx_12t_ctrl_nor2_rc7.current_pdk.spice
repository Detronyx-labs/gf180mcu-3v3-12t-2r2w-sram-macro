* NGSPICE file created from detronyx_12t_ctrl_nor2_rc7.ext - technology: gf180mcuD

.subckt detronyx_12t_ctrl_nor2_rc7 VDD VSS A B Y
X0 VSS A Y VSS nfet_03v3 ad=0.4642p pd=2.99u as=0.4642p ps=2.99u w=1.055u l=0.28u
X1 a_830_4345# A Y VDD pfet_03v3 ad=0.1232p pd=1u as=0.1232p ps=1u w=0.56u l=0.28u
X2 VDD B a_830_4345# VDD pfet_03v3 ad=0.1232p pd=1u as=0.1232p ps=1u w=0.56u l=0.28u
X3 VSS B Y VSS nfet_03v3 ad=0.4642p pd=2.99u as=0.4642p ps=2.99u w=1.055u l=0.28u
.ends
