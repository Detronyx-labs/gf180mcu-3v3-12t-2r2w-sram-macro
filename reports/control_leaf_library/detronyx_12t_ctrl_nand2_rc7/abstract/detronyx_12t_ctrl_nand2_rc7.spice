.subckt detronyx_12t_ctrl_nand2_rc7 VDD VSS A B Y
.ends detronyx_12t_ctrl_nand2_rc7
