* RC7 transistor-level reference CDL for detronyx_12t_ctrl_nand3_rc7
* Uses Tim-derived 3.3V GF180 MOS primitive dimensions.
.subckt detronyx_12t_ctrl_nand3_rc7 VDD VSS A B C Y
X1_nand_n0 Y A nand_mid0 VSS nfet_03v3 w=1.055u l=0.28u
X2_nand_n1 nand_mid0 B nand_mid1 VSS nfet_03v3 w=1.055u l=0.28u
X3_nand_n2 nand_mid1 C VSS VSS nfet_03v3 w=1.055u l=0.28u
X4_nand_p0 Y A VDD VDD pfet_03v3 w=0.56u l=0.28u
X5_nand_p1 Y B VDD VDD pfet_03v3 w=0.56u l=0.28u
X6_nand_p2 Y C VDD VDD pfet_03v3 w=0.56u l=0.28u
.ends detronyx_12t_ctrl_nand3_rc7
